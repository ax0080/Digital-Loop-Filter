//verilogA for DLF_test, test, veriloga

`include "constants.vams"
`include "disciplines.vams"

module Digital_Loop_Filter (
	input clk,
	input rstn,
	inout [7:0] master_in,
	output [7:0] slave_out,
	input lead
);

	//Define Parameter
	parameter inout_width = 8;
	parameter coeff_int_width = 2;
	parameter coeff_decimal_width = 18;
	parameter coeff_width = coeff_int_width + coeff_decimal_width;

	parameter real b0 = 0.0097690;
	parameter real b1 = 0.0101456;
	parameter real b2 = -0.0090159;
	parameter real b3 = -0.0093925;

	parameter real a1 = -1.64201;
	parameter real a2 = 0.70477;
	parameter real a3 = -0.06273;

	//Define Verilog
	real in0, in1, in2, in3;
	real out1, out2, out3;
	real out_sum;

	real int_temp, in_delay1, in_delay2, in_delay3;
	real out_delay1, out_delay2, out_delay3;

	real out_temp;

	//Combinational Circuit
	analog begin
		in0 = b0 * in_temp;
		in1 = b1 * in_delay1;
		in2 = b2 * in_delay2;
		in3 = b3 * in_delay3;

		out1 = a1 * out_delay1;
		out2 = a2 * out_delay2;
		out3 = a3 * out_delay3;

		out_sum = in0 + in1 + in2 + in3 - out1 - out2 - out3;
		out_temp = out_sum + 128;
	end

	analog begin
		@(initial_step)begin
		in_temp = 0;
		in_delay1 = 0;
		in_delay2 = 0;
		in_delay3 = 0;

		out_delay1 = 0;
		out_delay2 = 0;
		out_delay3 = 0;
	end

	always begin
		@(cross(V(clk)-0.6, +1) or cross(V(rstn)-0.6, -1))begin
			if(V(rstn) < 0.6)begin
				in_delay1 = 0;
				in_delay2 = 0;
				in_delay3 = 0;

				out_delay1 = 0;
				out_delay2 = 0;
				out_delay3 = 0;
			end
			else begin
				in_delay3 = in_delay2;
				in_delay2 = in_delay1;
				in_delay1 = in_temp;

				out_delay3 = out_delay2;
				out_delay2 = out_delay1;
				out_delay1 = out_sum;

			end
		end
	end

	genvar i;
	analog begin
		in_temp = 0;
		for(i=7; i>=0; i=i-1)begin
			in_temp = in_temp * 2;
			if(V(master_in[i]) > 0.6) begin
				in_temp = in_temp + 1;
			end
		end

		if(V(lead) < 0.6) in_temp = (-1) * in_temp;
	end

	real out_temp2;
	genvar j;
	analog begin
		out_temp2 = out_temp;
		for(j=7; j>=0; j=j-1)begin
			if(out_temp2 > 2 ** j)begin
				V(slave_out[j]) <+ 1.2;
				out_temp2 = out_temp2 - 2 ** j;
			end
			else begin
				V(slave_out[j]) <+ 0;
			end
		end
	end

endmodule
