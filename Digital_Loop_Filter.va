`include "disciplines.vams"

module Digital_Loop_Filter (
  input wire clk,
  input wire rstn,
  inout wire master_in,
  output reg slave_out
);

  // 定義 Verilog-A 參數
  parameter inout_width = 8;
  parameter coeff_int_width = 2;
  parameter coeff_decimal_width = 18;
  parameter coeff_width = coeff_int_width + coeff_decimal_width;

  parameter real b0 = 20'b00_0000_0001_0100_0000_00;
  parameter real b1 = 20'b00_0000_0001_0100_1100_01;
  parameter real b2 = 20'b11_1111_1110_1101_1000_10;
  parameter real b3 = 20'b11_1111_1110_1100_1100_00;

  parameter real a1 = 20'b01_1010_0100_0101_1010_00;
  parameter real a2 = 20'b00_1011_0100_0110_1011_11;
  parameter real a3 = 20'b11_1110_1111_1111_0000_11;

  // 定義 Verilog-A 變數
  real in1, in2, in3;
  real out1, out2, out3;
  real out_sum;

  // Analog 模擬區域
  analog begin
    // 定義 Verilog-A 模擬方程
    in1 = b1 * in_delay1;
    in2 = b2 * in_delay2;
    in3 = b3 * in_delay3;

    out1 = a1 * out_delay1;
    out2 = a2 * out_delay2;
    out3 = a3 * out_delay3;

    out_sum = b0 + in1 + in2 + in3 - out1 - out2 - out3;
    slave_out = out_sum[coeff_decimal_width + coeff_width - 1 : coeff_decimal_width];
  end

  // 包含 Verilog-A 初始化區塊
  initial begin
    in_delay1 = 0;
    in_delay2 = 0;
    in_delay3 = 0;

    out_delay1 = 0;
    out_delay2 = 0;
    out_delay3 = 0;
  end

  // 包含 Verilog-A 每個時脈週期區塊
  always @(posedge clk) begin
    if (!rstn) begin
      in_delay1 = 0;
      in_delay2 = 0;
      in_delay3 = 0;

      out_delay1 = 0;
      out_delay2 = 0;
      out_delay3 = 0;
    end
    else begin
      in_delay1 = master_in;
      in_delay2 = in_delay1;
      in_delay3 = in_delay2;

      out_delay1 = slave_out; // 假設 output_int 是連接到 out_delay1 的 Verilog 信號
      out_delay2 = out_delay1;
      out_delay3 = out_delay2;
    end
  end

endmodule
